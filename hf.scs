simulator lang=spectre

include "~/ECEN752/flash_sim_for_class/flash_fets.pm"
include "~/ECEN752/14nfet.pm"
include "~/ECEN752/14pfet.pm"
include "~/ECEN752/param.scs"
include "~/ECEN752/45nm_HP.pm"
include "~/ECEN752/hf_subckt_45nm.scs"

parameters wn=45n lmin=45n wp=wn vdd=1

;parameters Q00 Q01 Q02 Q03 Q04 Q05 Q06 Q07 Q08 Q09 Q010 Q011 Q012 Q013 Q014 Q015 Q016 Q017 Q018 Q019 Q020 Q021 Q022 Q023 Q024 Q025 Q026 Q027 Q028 Q029 Q030 Q031 Q032 Q033 Q034 Q035 Q036 Q037 Q038 Q039 Q040 Q041 Q042 Q043 Q044 Q045 Q046 Q047 Q048 Q049 Q050 Q051 Q052 Q053 Q054 Q055 Q056 Q057 Q058 Q059 Q060 Q061 Q062 Q063 Q064 Q065 Q066 Q067 Q068 Q069 Q070 Q071 Q072 Q073 Q074 Q075 Q076 Q077 Q078 Q079 Q080 Q081 Q082 Q083 Q084 Q085 Q086 Q087 Q088 Q089 Q090 Q091 Q092 Q093 Q094 Q095 Q096 Q097 Q098 Q099
;parameters Q10 Q11 Q12 Q13 Q14 Q15 Q16 Q17 Q18 Q19 Q110 Q111 Q112 Q113 Q114 Q115 Q116 Q117 Q118 Q119 Q120 Q121 Q122 Q123 Q124 Q125 Q126 Q127 Q128 Q129 Q130 Q131 Q132 Q133 Q134 Q135 Q136 Q137 Q138 Q139 Q140 Q141 Q142 Q143 Q144 Q145 Q146 Q147 Q148 Q149 Q150 Q151 Q152 Q153 Q154 Q155 Q156 Q157 Q158 Q159 Q160 Q161 Q162 Q163 Q164 Q165 Q166 Q167 Q168 Q169 Q170 Q171 Q172 Q173 Q174 Q175 Q176 Q177 Q178 Q179 Q180 Q181 Q182 Q183 Q184 Q185 Q186 Q187 Q188 Q189 Q190 Q191 Q192 Q193 Q194 Q195 Q196 Q197 Q198 Q199
;parameters Q20 Q21 Q22 Q23 Q24 Q25 Q26 Q27 Q28 Q29 Q210 Q211 Q212 Q213 Q214 Q215 Q216 Q217 Q218 Q219 Q220 Q221 Q222 Q223 Q224 Q225 Q226 Q227 Q228 Q229 Q230 Q231 Q232 Q233 Q234 Q235 Q236 Q237 Q238 Q239 Q240 Q241 Q242 Q243 Q244 Q245 Q246 Q247 Q248 Q249 Q250 Q251 Q252 Q253 Q254 Q255 Q256 Q257 Q258 Q259 Q260 Q261 Q262 Q263 Q264 Q265 Q266 Q267 Q268 Q269 Q270 Q271 Q272 Q273 Q274 Q275 Q276 Q277 Q278 Q279 Q280 Q281 Q282 Q283 Q284 Q285 Q286 Q287 Q288 Q289 Q290 Q291 Q292 Q293 Q294 Q295 Q296 Q297 Q298 Q299
;parameters Q30 Q31 Q32 Q33 Q34 Q35 Q36 Q37 Q38 Q39 Q310 Q311 Q312 Q313 Q314 Q315 Q316 Q317 Q318 Q319 Q320 Q321 Q322 Q323 Q324 Q325 Q326 Q327 Q328 Q329 Q330 Q331 Q332 Q333 Q334 Q335 Q336 Q337 Q338 Q339 Q340 Q341 Q342 Q343 Q344 Q345 Q346 Q347 Q348 Q349 Q350 Q351 Q352 Q353 Q354 Q355 Q356 Q357 Q358 Q359 Q360 Q361 Q362 Q363 Q364 Q365 Q366 Q367 Q368 Q369 Q370 Q371 Q372 Q373 Q374 Q375 Q376 Q377 Q378 Q379 Q380 Q381 Q382 Q383 Q384 Q385 Q386 Q387 Q388 Q389 Q390 Q391 Q392 Q393 Q394 Q395 Q396 Q397 Q398 Q399
;parameters Q40 Q41 Q42 Q43 Q44 Q45 Q46 Q47 Q48 Q49 Q410 Q411 Q412 Q413 Q414 Q415 Q416 Q417 Q418 Q419 Q420 Q421 Q422 Q423 Q424 Q425 Q426 Q427 Q428 Q429 Q430 Q431 Q432 Q433 Q434 Q435 Q436 Q437 Q438 Q439 Q440 Q441 Q442 Q443 Q444 Q445 Q446 Q447 Q448 Q449 Q450 Q451 Q452 Q453 Q454 Q455 Q456 Q457 Q458 Q459 Q460 Q461 Q462 Q463 Q464 Q465 Q466 Q467 Q468 Q469 Q470 Q471 Q472 Q473 Q474 Q475 Q476 Q477 Q478 Q479 Q480 Q481 Q482 Q483 Q484 Q485 Q486 Q487 Q488 Q489 Q490 Q491 Q492 Q493 Q494 Q495 Q496 Q497 Q498 Q499
;parameters Q50 Q51 Q52 Q53 Q54 Q55 Q56 Q57 Q58 Q59 Q510 Q511 Q512 Q513 Q514 Q515 Q516 Q517 Q518 Q519 Q520 Q521 Q522 Q523 Q524 Q525 Q526 Q527 Q528 Q529 Q530 Q531 Q532 Q533 Q534 Q535 Q536 Q537 Q538 Q539 Q540 Q541 Q542 Q543 Q544 Q545 Q546 Q547 Q548 Q549 Q550 Q551 Q552 Q553 Q554 Q555 Q556 Q557 Q558 Q559 Q560 Q561 Q562 Q563 Q564 Q565 Q566 Q567 Q568 Q569 Q570 Q571 Q572 Q573 Q574 Q575 Q576 Q577 Q578 Q579 Q580 Q581 Q582 Q583 Q584 Q585 Q586 Q587 Q588 Q589 Q590 Q591 Q592 Q593 Q594 Q595 Q596 Q597 Q598 Q599

parameters Q00=0 Q01=0 Q02=1 Q03=0 Q04=1 Q05=1 Q06=1 Q07=0 Q08=0 Q09=1 Q010=0 Q011=0 Q012=1 Q013=0 Q014=0 Q015=1 Q016=1 Q017=1 Q018=0 Q019=1 Q020=1 Q021=0 Q022=1 Q023=0 Q024=1 Q025=1 Q026=0 Q027=1 Q028=0 Q029=1 Q030=0 Q031=0 Q032=1 Q033=0 Q034=0 Q035=0 Q036=1 Q037=1 Q038=1 Q039=1 Q040=1 Q041=1 Q042=0 Q043=0 Q044=1 Q045=0 Q046=0 Q047=0 Q048=0 Q049=0 Q050=1 Q051=0 Q052=0 Q053=0 Q054=1 Q055=1 Q056=0 Q057=0 Q058=1 Q059=1 Q060=0 Q061=0 Q062=1 Q063=1 Q064=1 Q065=1 Q066=0 Q067=0 Q068=0 Q069=0 Q070=0 Q071=0 Q072=0 Q073=0 Q074=1 Q075=0 Q076=1 Q077=1 Q078=1 Q079=1 Q080=1 Q081=0 Q082=1 Q083=0 Q084=0 Q085=0 Q086=0 Q087=1 Q088=0 Q089=1 Q090=0 Q091=1 Q092=1 Q093=1 Q094=0 Q095=0 Q096=0 Q097=0 Q098=1 Q099=0
parameters Q10=1 Q11=1 Q12=0 Q13=1 Q14=0 Q15=0 Q16=1 Q17=0 Q18=0 Q19=1 Q110=0 Q111=0 Q112=1 Q113=1 Q114=1 Q115=0 Q116=0 Q117=1 Q118=0 Q119=0 Q120=1 Q121=0 Q122=0 Q123=0 Q124=0 Q125=1 Q126=1 Q127=0 Q128=1 Q129=0 Q130=0 Q131=1 Q132=0 Q133=1 Q134=0 Q135=0 Q136=1 Q137=0 Q138=0 Q139=1 Q140=0 Q141=1 Q142=0 Q143=0 Q144=1 Q145=0 Q146=0 Q147=1 Q148=0 Q149=1 Q150=0 Q151=1 Q152=0 Q153=1 Q154=0 Q155=1 Q156=0 Q157=0 Q158=0 Q159=0 Q160=0 Q161=0 Q162=0 Q163=1 Q164=1 Q165=0 Q166=1 Q167=0 Q168=0 Q169=0 Q170=1 Q171=1 Q172=0 Q173=1 Q174=1 Q175=1 Q176=1 Q177=0 Q178=0 Q179=1 Q180=0 Q181=1 Q182=1 Q183=1 Q184=1 Q185=1 Q186=0 Q187=1 Q188=0 Q189=1 Q190=1 Q191=0 Q192=1 Q193=1 Q194=0 Q195=1 Q196=0 Q197=0 Q198=1 Q199=1
parameters Q20=1 Q21=1 Q22=0 Q23=1 Q24=0 Q25=1 Q26=1 Q27=0 Q28=0 Q29=0 Q210=0 Q211=1 Q212=0 Q213=0 Q214=0 Q215=0 Q216=1 Q217=1 Q218=1 Q219=0 Q220=1 Q221=0 Q222=0 Q223=0 Q224=1 Q225=1 Q226=1 Q227=0 Q228=1 Q229=1 Q230=1 Q231=1 Q232=0 Q233=1 Q234=0 Q235=0 Q236=0 Q237=1 Q238=1 Q239=1 Q240=1 Q241=1 Q242=0 Q243=1 Q244=0 Q245=1 Q246=1 Q247=1 Q248=0 Q249=1 Q250=1 Q251=0 Q252=0 Q253=0 Q254=1 Q255=0 Q256=0 Q257=0 Q258=1 Q259=0 Q260=1 Q261=0 Q262=0 Q263=0 Q264=1 Q265=1 Q266=0 Q267=1 Q268=0 Q269=0 Q270=0 Q271=1 Q272=1 Q273=0 Q274=1 Q275=1 Q276=0 Q277=0 Q278=1 Q279=1 Q280=0 Q281=1 Q282=0 Q283=1 Q284=1 Q285=0 Q286=0 Q287=1 Q288=0 Q289=1 Q290=0 Q291=0 Q292=1 Q293=1 Q294=0 Q295=0 Q296=0 Q297=1 Q298=1 Q299=0
parameters Q30=0 Q31=1 Q32=1 Q33=1 Q34=1 Q35=1 Q36=0 Q37=1 Q38=1 Q39=0 Q310=1 Q311=0 Q312=1 Q313=1 Q314=1 Q315=1 Q316=0 Q317=1 Q318=1 Q319=1 Q320=1 Q321=0 Q322=0 Q323=1 Q324=0 Q325=1 Q326=1 Q327=1 Q328=1 Q329=0 Q330=1 Q331=0 Q332=0 Q333=0 Q334=1 Q335=0 Q336=0 Q337=1 Q338=1 Q339=1 Q340=1 Q341=1 Q342=0 Q343=0 Q344=0 Q345=0 Q346=0 Q347=1 Q348=1 Q349=1 Q350=0 Q351=0 Q352=1 Q353=0 Q354=0 Q355=1 Q356=1 Q357=0 Q358=1 Q359=0 Q360=1 Q361=1 Q362=1 Q363=0 Q364=1 Q365=0 Q366=1 Q367=0 Q368=0 Q369=1 Q370=1 Q371=1 Q372=1 Q373=0 Q374=1 Q375=0 Q376=0 Q377=0 Q378=1 Q379=0 Q380=1 Q381=1 Q382=0 Q383=0 Q384=1 Q385=0 Q386=1 Q387=1 Q388=1 Q389=1 Q390=0 Q391=1 Q392=1 Q393=0 Q394=0 Q395=1 Q396=1 Q397=0 Q398=0 Q399=1
parameters Q40=0 Q41=1 Q42=1 Q43=0 Q44=1 Q45=0 Q46=0 Q47=1 Q48=0 Q49=1 Q410=1 Q411=1 Q412=1 Q413=0 Q414=1 Q415=1 Q416=0 Q417=0 Q418=1 Q419=1 Q420=1 Q421=1 Q422=0 Q423=1 Q424=1 Q425=1 Q426=0 Q427=0 Q428=0 Q429=0 Q430=0 Q431=1 Q432=1 Q433=0 Q434=0 Q435=0 Q436=0 Q437=1 Q438=1 Q439=0 Q440=0 Q441=0 Q442=0 Q443=0 Q444=1 Q445=0 Q446=1 Q447=1 Q448=1 Q449=0 Q450=0 Q451=1 Q452=1 Q453=0 Q454=1 Q455=1 Q456=0 Q457=1 Q458=0 Q459=0 Q460=0 Q461=1 Q462=0 Q463=1 Q464=0 Q465=1 Q466=1 Q467=0 Q468=0 Q469=1 Q470=0 Q471=1 Q472=0 Q473=0 Q474=1 Q475=1 Q476=1 Q477=1 Q478=0 Q479=0 Q480=1 Q481=0 Q482=1 Q483=0 Q484=1 Q485=0 Q486=1 Q487=1 Q488=1 Q489=1 Q490=0 Q491=0 Q492=1 Q493=1 Q494=1 Q495=0 Q496=0 Q497=0 Q498=1 Q499=1
parameters Q50=1 Q51=1 Q52=0 Q53=0 Q54=0 Q55=1 Q56=0 Q57=0 Q58=1 Q59=1 Q510=1 Q511=0 Q512=0 Q513=1 Q514=1 Q515=1 Q516=1 Q517=1 Q518=0 Q519=0 Q520=0 Q521=1 Q522=0 Q523=1 Q524=0 Q525=0 Q526=1 Q527=0 Q528=0 Q529=1 Q530=0 Q531=1 Q532=1 Q533=0 Q534=0 Q535=0 Q536=1 Q537=0 Q538=1 Q539=1 Q540=0 Q541=1 Q542=1 Q543=1 Q544=0 Q545=1 Q546=0 Q547=0 Q548=1 Q549=1 Q550=0 Q551=1 Q552=0 Q553=1 Q554=0 Q555=0 Q556=1 Q557=1 Q558=1 Q559=1 Q560=1 Q561=0 Q562=1 Q563=0 Q564=0 Q565=1 Q566=0 Q567=0 Q568=1 Q569=0 Q570=0 Q571=0 Q572=0 Q573=1 Q574=0 Q575=1 Q576=0 Q577=1 Q578=0 Q579=1 Q580=0 Q581=1 Q582=0 Q583=0 Q584=0 Q585=1 Q586=1 Q587=1 Q588=1 Q589=1 Q590=1 Q591=0 Q592=0 Q593=1 Q594=0 Q595=1 Q596=1 Q597=1 Q598=1 Q599=0

;parameters key0 key1 key2 key3 key4 key5 key6 key7 key8 key9 key10 key11 key12 key13 key14 key15 key16 key17 key18 key19 key20 key21 key22 key23 key24 key25 key26 key27 key28 key29 key30 key31 key32 key33 key34 key35 key36 key37 key38 key39 key40 key41 key42 key43 key44 key45 key46 key47 key48 key49 key50 key51 key52 key53 key54 key55 key56 key57 key58 key59 key60 key61 key62 key63 key64 key65 key66 key67 key68 key69 key70 key71 key72 key73 key74 key75 key76 key77 key78 key79 key80 key81 key82 key83 key84 key85 key86 key87 key88 key89 key90 key91 key92 key93 key94 key95 key96 key97 key98 key99

;parameters out00 out01 out02 out03 out04 out05 out06 out07 out08 out09 out010 out011 out012 out013 out014 out015 out016 out017 out018 out019 out020 out021 out022 out023 out024 out025 out026 out027 out028 out029 out030 out031 out032 out033 out034 out035 out036 out037 out038 out039 out040 out041 out042 out043 out044 out045 out046 out047 out048 out049 out050 out051 out052 out053 out054 out055 out056 out057 out058 out059 out060 out061 out062 out063 out064 out065 out066 out067 out068 out069 out070 out071 out072 out073 out074 out075 out076 out077 out078 out079 out080 out081 out082 out083 out084 out085 out086 out087 out088 out089 out090 out091 out092 out093 out094 out095 out096 out097 out098 out099
;parameters out10 out11 out12 out13 out14 out15 out16 out17 out18 out19 out110 out111 out112 out113 out114 out115 out116 out117 out118 out119 out120 out121 out122 out123 out124 out125 out126 out127 out128 out129 out130 out131 out132 out133 out134 out135 out136 out137 out138 out139 out140 out141 out142 out143 out144 out145 out146 out147 out148 out149 out150 out151 out152 out153 out154 out155 out156 out157 out158 out159 out160 out161 out162 out163 out164 out165 out166 out167 out168 out169 out170 out171 out172 out173 out174 out175 out176 out177 out178 out179 out180 out181 out182 out183 out184 out185 out186 out187 out188 out189 out190 out191 out192 out193 out194 out195 out196 out197 out198 out199
;parameters out20 out21 out22 out23 out24 out25 out26 out27 out28 out29 out210 out211 out212 out213 out214 out215 out216 out217 out218 out219 out220 out221 out222 out223 out224 out225 out226 out227 out228 out229 out230 out231 out232 out233 out234 out235 out236 out237 out238 out239 out240 out241 out242 out243 out244 out245 out246 out247 out248 out249 out250 out251 out252 out253 out254 out255 out256 out257 out258 out259 out260 out261 out262 out263 out264 out265 out266 out267 out268 out269 out270 out271 out272 out273 out274 out275 out276 out277 out278 out279 out280 out281 out282 out283 out284 out285 out286 out287 out288 out289 out290 out291 out292 out293 out294 out295 out296 out297 out298 out299
;parameters out30 out31 out32 out33 out34 out35 out36 out37 out38 out39 out310 out311 out312 out313 out314 out315 out316 out317 out318 out319 out320 out321 out322 out323 out324 out325 out326 out327 out328 out329 out330 out331 out332 out333 out334 out335 out336 out337 out338 out339 out340 out341 out342 out343 out344 out345 out346 out347 out348 out349 out350 out351 out352 out353 out354 out355 out356 out357 out358 out359 out360 out361 out362 out363 out364 out365 out366 out367 out368 out369 out370 out371 out372 out373 out374 out375 out376 out377 out378 out379 out380 out381 out382 out383 out384 out385 out386 out387 out388 out389 out390 out391 out392 out393 out394 out395 out396 out397 out398 out399
;parameters out40 out41 out42 out43 out44 out45 out46 out47 out48 out49 out410 out411 out412 out413 out414 out415 out416 out417 out418 out419 out420 out421 out422 out423 out424 out425 out426 out427 out428 out429 out430 out431 out432 out433 out434 out435 out436 out437 out438 out439 out440 out441 out442 out443 out444 out445 out446 out447 out448 out449 out450 out451 out452 out453 out454 out455 out456 out457 out458 out459 out460 out461 out462 out463 out464 out465 out466 out467 out468 out469 out470 out471 out472 out473 out474 out475 out476 out477 out478 out479 out480 out481 out482 out483 out484 out485 out486 out487 out488 out489 out490 out491 out492 out493 out494 out495 out496 out497 out498 out499
;parameters out50 out51 out52 out53 out54 out55 out56 out57 out58 out59 out510 out511 out512 out513 out514 out515 out516 out517 out518 out519 out520 out521 out522 out523 out524 out525 out526 out527 out528 out529 out530 out531 out532 out533 out534 out535 out536 out537 out538 out539 out540 out541 out542 out543 out544 out545 out546 out547 out548 out549 out550 out551 out552 out553 out554 out555 out556 out557 out558 out559 out560 out561 out562 out563 out564 out565 out566 out567 out568 out569 out570 out571 out572 out573 out574 out575 out576 out577 out578 out579 out580 out581 out582 out583 out584 out585 out586 out587 out588 out589 out590 out591 out592 out593 out594 out595 out596 out597 out598 out599

;Hash function circuit description
row0 (key0 key1 key2 key3 key4 key5 key6 key7 key8 key9 key10 key11 key12 key13 key14 key15 key16 key17 key18 key19 key20 key21 key22 key23 key24 key25 key26 key27 key28 key29 key30 key31 key32 key33 key34 key35 key36 key37 key38 key39 key40 key41 key42 key43 key44 key45 key46 key47 key48 key49 key50 key51 key52 key53 key54 key55 key56 key57 key58 key59 key60 key61 key62 key63 key64 key65 key66 key67 key68 key69 key70 key71 key72 key73 key74 key75 key76 key77 key78 key79 key80 key81 key82 key83 key84 key85 key86 key87 key88 key89 key90 key91 key92 key93 key94 key95 key96 key97 key98 key99 Q00 Q01 Q02 Q03 Q04 Q05 Q06 Q07 Q08 Q09 Q010 Q011 Q012 Q013 Q014 Q015 Q016 Q017 Q018 Q019 Q020 Q021 Q022 Q023 Q024 Q025 Q026 Q027 Q028 Q029 Q030 Q031 Q032 Q033 Q034 Q035 Q036 Q037 Q038 Q039 Q040 Q041 Q042 Q043 Q044 Q045 Q046 Q047 Q048 Q049 Q050 Q051 Q052 Q053 Q054 Q055 Q056 Q057 Q058 Q059 Q060 Q061 Q062 Q063 Q064 Q065 Q066 Q067 Q068 Q069 Q070 Q071 Q072 Q073 Q074 Q075 Q076 Q077 Q078 Q079 Q080 Q081 Q082 Q083 Q084 Q085 Q086 Q087 Q088 Q089 Q090 Q091 Q092 Q093 Q094 Q095 Q096 Q097 Q098 Q099 out00 out01 out02 out03 out04 out05 out06 out07 out08 out09 out010 out011 out012 out013 out014 out015 out016 out017 out018 out019 out020 out021 out022 out023 out024 out025 out026 out027 out028 out029 out030 out031 out032 out033 out034 out035 out036 out037 out038 out039 out040 out041 out042 out043 out044 out045 out046 out047 out048 out049 out050 out051 out052 out053 out054 out055 out056 out057 out058 out059 out060 out061 out062 out063 out064 out065 out066 out067 out068 out069 out070 out071 out072 out073 out074 out075 out076 out077 out078 out079 out080 out081 out082 out083 out084 out085 out086 out087 out088 out089 out090 out091 out092 out093 out094 out095 out096 out097 out098 out099 VDD VSS) row
row1 (key0 key1 key2 key3 key4 key5 key6 key7 key8 key9 key10 key11 key12 key13 key14 key15 key16 key17 key18 key19 key20 key21 key22 key23 key24 key25 key26 key27 key28 key29 key30 key31 key32 key33 key34 key35 key36 key37 key38 key39 key40 key41 key42 key43 key44 key45 key46 key47 key48 key49 key50 key51 key52 key53 key54 key55 key56 key57 key58 key59 key60 key61 key62 key63 key64 key65 key66 key67 key68 key69 key70 key71 key72 key73 key74 key75 key76 key77 key78 key79 key80 key81 key82 key83 key84 key85 key86 key87 key88 key89 key90 key91 key92 key93 key94 key95 key96 key97 key98 key99 Q10 Q11 Q12 Q13 Q14 Q15 Q16 Q17 Q18 Q19 Q110 Q111 Q112 Q113 Q114 Q115 Q116 Q117 Q118 Q119 Q120 Q121 Q122 Q123 Q124 Q125 Q126 Q127 Q128 Q129 Q130 Q131 Q132 Q133 Q134 Q135 Q136 Q137 Q138 Q139 Q140 Q141 Q142 Q143 Q144 Q145 Q146 Q147 Q148 Q149 Q150 Q151 Q152 Q153 Q154 Q155 Q156 Q157 Q158 Q159 Q160 Q161 Q162 Q163 Q164 Q165 Q166 Q167 Q168 Q169 Q170 Q171 Q172 Q173 Q174 Q175 Q176 Q177 Q178 Q179 Q180 Q181 Q182 Q183 Q184 Q185 Q186 Q187 Q188 Q189 Q190 Q191 Q192 Q193 Q194 Q195 Q196 Q197 Q198 Q199 out10 out11 out12 out13 out14 out15 out16 out17 out18 out19 out110 out111 out112 out113 out114 out115 out116 out117 out118 out119 out120 out121 out122 out123 out124 out125 out126 out127 out128 out129 out130 out131 out132 out133 out134 out135 out136 out137 out138 out139 out140 out141 out142 out143 out144 out145 out146 out147 out148 out149 out150 out151 out152 out153 out154 out155 out156 out157 out158 out159 out160 out161 out162 out163 out164 out165 out166 out167 out168 out169 out170 out171 out172 out173 out174 out175 out176 out177 out178 out179 out180 out181 out182 out183 out184 out185 out186 out187 out188 out189 out190 out191 out192 out193 out194 out195 out196 out197 out198 out199 VDD VSS) row
row2 (key0 key1 key2 key3 key4 key5 key6 key7 key8 key9 key10 key11 key12 key13 key14 key15 key16 key17 key18 key19 key20 key21 key22 key23 key24 key25 key26 key27 key28 key29 key30 key31 key32 key33 key34 key35 key36 key37 key38 key39 key40 key41 key42 key43 key44 key45 key46 key47 key48 key49 key50 key51 key52 key53 key54 key55 key56 key57 key58 key59 key60 key61 key62 key63 key64 key65 key66 key67 key68 key69 key70 key71 key72 key73 key74 key75 key76 key77 key78 key79 key80 key81 key82 key83 key84 key85 key86 key87 key88 key89 key90 key91 key92 key93 key94 key95 key96 key97 key98 key99 Q20 Q21 Q22 Q23 Q24 Q25 Q26 Q27 Q28 Q29 Q210 Q211 Q212 Q213 Q214 Q215 Q216 Q217 Q218 Q219 Q220 Q221 Q222 Q223 Q224 Q225 Q226 Q227 Q228 Q229 Q230 Q231 Q232 Q233 Q234 Q235 Q236 Q237 Q238 Q239 Q240 Q241 Q242 Q243 Q244 Q245 Q246 Q247 Q248 Q249 Q250 Q251 Q252 Q253 Q254 Q255 Q256 Q257 Q258 Q259 Q260 Q261 Q262 Q263 Q264 Q265 Q266 Q267 Q268 Q269 Q270 Q271 Q272 Q273 Q274 Q275 Q276 Q277 Q278 Q279 Q280 Q281 Q282 Q283 Q284 Q285 Q286 Q287 Q288 Q289 Q290 Q291 Q292 Q293 Q294 Q295 Q296 Q297 Q298 Q299 out20 out21 out22 out23 out24 out25 out26 out27 out28 out29 out210 out211 out212 out213 out214 out215 out216 out217 out218 out219 out220 out221 out222 out223 out224 out225 out226 out227 out228 out229 out230 out231 out232 out233 out234 out235 out236 out237 out238 out239 out240 out241 out242 out243 out244 out245 out246 out247 out248 out249 out250 out251 out252 out253 out254 out255 out256 out257 out258 out259 out260 out261 out262 out263 out264 out265 out266 out267 out268 out269 out270 out271 out272 out273 out274 out275 out276 out277 out278 out279 out280 out281 out282 out283 out284 out285 out286 out287 out288 out289 out290 out291 out292 out293 out294 out295 out296 out297 out298 out299 VDD VSS) row

binsel0 (out00 out01 out02 out03 out04 out05 out06 out07 out08 out09 out010 out011 out012 out013 out014 out015 out016 out017 out018 out019 out020 out021 out022 out023 out024 out025 out026 out027 out028 out029 out030 out031 out032 out033 out034 out035 out036 out037 out038 out039 out040 out041 out042 out043 out044 out045 out046 out047 out048 out049 out050 out051 out052 out053 out054 out055 out056 out057 out058 out059 out060 out061 out062 out063 out064 out065 out066 out067 out068 out069 out070 out071 out072 out073 out074 out075 out076 out077 out078 out079 out080 out081 out082 out083 out084 out085 out086 out087 out088 out089 out090 out091 out092 out093 out094 out095 out096 out097 out098 out099 bin0 VDD VSS) XOR100
binsel1 (out10 out11 out12 out13 out14 out15 out16 out17 out18 out19 out110 out111 out112 out113 out114 out115 out116 out117 out118 out119 out120 out121 out122 out123 out124 out125 out126 out127 out128 out129 out130 out131 out132 out133 out134 out135 out136 out137 out138 out139 out140 out141 out142 out143 out144 out145 out146 out147 out148 out149 out150 out151 out152 out153 out154 out155 out156 out157 out158 out159 out160 out161 out162 out163 out164 out165 out166 out167 out168 out169 out170 out171 out172 out173 out174 out175 out176 out177 out178 out179 out180 out181 out182 out183 out184 out185 out186 out187 out188 out189 out190 out191 out192 out193 out194 out195 out196 out197 out198 out199 bin1 VDD VSS) XOR100
binsel2 (out20 out21 out22 out23 out24 out25 out26 out27 out28 out29 out210 out211 out212 out213 out214 out215 out216 out217 out218 out219 out220 out221 out222 out223 out224 out225 out226 out227 out228 out229 out230 out231 out232 out233 out234 out235 out236 out237 out238 out239 out240 out241 out242 out243 out244 out245 out246 out247 out248 out249 out250 out251 out252 out253 out254 out255 out256 out257 out258 out259 out260 out261 out262 out263 out264 out265 out266 out267 out268 out269 out270 out271 out272 out273 out274 out275 out276 out277 out278 out279 out280 out281 out282 out283 out284 out285 out286 out287 out288 out289 out290 out291 out292 out293 out294 out295 out296 out297 out298 out299 bin2 VDD VSS) XOR100

vgnd (gnd 0) vsource dc=0
vvdd (vdd 0) vsource dc=0.8

vpwl0 (key0 0) vsource type=pwl pwlperiod=100 wave=[0n 0 2.82p 1 100p 1 102.82p 0 200p 0]
vpwl1 (key1 0) vsource type=pwl pwlperiod=100 wave=[0n 0 2.82p 1 100p 1 102.82p 0 200p 0]
vpwl2 (key2 0) vsource type=pwl pwlperiod=100 wave=[0n 0 2.82p 1 100p 1 102.82p 0 200p 0]
vpwl3 (key3 0) vsource type=pwl pwlperiod=100 wave=[0n 0 2.82p 1 100p 1 102.82p 0 200p 0]
vpwl4 (key4 0) vsource type=pwl pwlperiod=100 wave=[0n 0 2.82p 1 100p 1 102.82p 0 200p 0]
vpwl5 (key5 0) vsource type=pwl pwlperiod=100 wave=[0n 0 2.82p 1 100p 1 102.82p 0 200p 0]
vpwl6 (key6 0) vsource type=pwl pwlperiod=100 wave=[0n 0 2.82p 1 100p 1 102.82p 0 200p 0]
vpwl7 (key7 0) vsource type=pwl pwlperiod=100 wave=[0n 0 2.82p 1 100p 1 102.82p 0 200p 0]
vpwl8 (key8 0) vsource type=pwl pwlperiod=100 wave=[0n 0 2.82p 1 100p 1 102.82p 0 200p 0]
vpwl9 (key9 0) vsource type=pwl pwlperiod=100 wave=[0n 0 2.82p 1 100p 1 102.82p 0 200p 0]
vpwl10 (key10 0) vsource type=pwl pwlperiod=100 wave=[0n 0 2.82p 1 100p 1 102.82p 0 200p 0]
vpwl11 (key11 0) vsource type=pwl pwlperiod=100 wave=[0n 0 2.82p 1 100p 1 102.82p 0 200p 0]
vpwl12 (key12 0) vsource type=pwl pwlperiod=100 wave=[0n 0 2.82p 1 100p 1 102.82p 0 200p 0]
vpwl13 (key13 0) vsource type=pwl pwlperiod=100 wave=[0n 0 2.82p 1 100p 1 102.82p 0 200p 0]
vpwl14 (key14 0) vsource type=pwl pwlperiod=100 wave=[0n 0 2.82p 1 100p 1 102.82p 0 200p 0]
vpwl15 (key15 0) vsource type=pwl pwlperiod=100 wave=[0n 0 2.82p 1 100p 1 102.82p 0 200p 0]
vpwl16 (key16 0) vsource type=pwl pwlperiod=100 wave=[0n 0 2.82p 1 100p 1 102.82p 0 200p 0]
vpwl17 (key17 0) vsource type=pwl pwlperiod=100 wave=[0n 0 2.82p 1 100p 1 102.82p 0 200p 0]
vpwl18 (key18 0) vsource type=pwl pwlperiod=100 wave=[0n 0 2.82p 1 100p 1 102.82p 0 200p 0]
vpwl19 (key19 0) vsource type=pwl pwlperiod=100 wave=[0n 0 2.82p 1 100p 1 102.82p 0 200p 0]
vpwl20 (key20 0) vsource type=pwl pwlperiod=100 wave=[0n 0 2.82p 1 100p 1 102.82p 0 200p 0]
vpwl21 (key21 0) vsource type=pwl pwlperiod=100 wave=[0n 0 2.82p 1 100p 1 102.82p 0 200p 0]
vpwl22 (key22 0) vsource type=pwl pwlperiod=100 wave=[0n 0 2.82p 1 100p 1 102.82p 0 200p 0]
vpwl23 (key23 0) vsource type=pwl pwlperiod=100 wave=[0n 0 2.82p 1 100p 1 102.82p 0 200p 0]
vpwl24 (key24 0) vsource type=pwl pwlperiod=100 wave=[0n 0 2.82p 1 100p 1 102.82p 0 200p 0]
vpwl25 (key25 0) vsource type=pwl pwlperiod=100 wave=[0n 0 2.82p 1 100p 1 102.82p 0 200p 0]
vpwl26 (key26 0) vsource type=pwl pwlperiod=100 wave=[0n 0 2.82p 1 100p 1 102.82p 0 200p 0]
vpwl27 (key27 0) vsource type=pwl pwlperiod=100 wave=[0n 0 2.82p 1 100p 1 102.82p 0 200p 0]
vpwl28 (key28 0) vsource type=pwl pwlperiod=100 wave=[0n 0 2.82p 1 100p 1 102.82p 0 200p 0]
vpwl29 (key29 0) vsource type=pwl pwlperiod=100 wave=[0n 0 2.82p 1 100p 1 102.82p 0 200p 0]
vpwl30 (key30 0) vsource type=pwl pwlperiod=100 wave=[0n 0 2.82p 1 100p 1 102.82p 0 200p 0]
vpwl31 (key31 0) vsource type=pwl pwlperiod=100 wave=[0n 0 2.82p 1 100p 1 102.82p 0 200p 0]
vpwl32 (key32 0) vsource type=pwl pwlperiod=100 wave=[0n 0 2.82p 1 100p 1 102.82p 0 200p 0]
vpwl33 (key33 0) vsource type=pwl pwlperiod=100 wave=[0n 0 2.82p 1 100p 1 102.82p 0 200p 0]
vpwl34 (key34 0) vsource type=pwl pwlperiod=100 wave=[0n 0 2.82p 1 100p 1 102.82p 0 200p 0]
vpwl35 (key35 0) vsource type=pwl pwlperiod=100 wave=[0n 0 2.82p 1 100p 1 102.82p 0 200p 0]
vpwl36 (key36 0) vsource type=pwl pwlperiod=100 wave=[0n 0 2.82p 1 100p 1 102.82p 0 200p 0]
vpwl37 (key37 0) vsource type=pwl pwlperiod=100 wave=[0n 0 2.82p 1 100p 1 102.82p 0 200p 0]
vpwl38 (key38 0) vsource type=pwl pwlperiod=100 wave=[0n 0 2.82p 1 100p 1 102.82p 0 200p 0]
vpwl39 (key39 0) vsource type=pwl pwlperiod=100 wave=[0n 0 2.82p 1 100p 1 102.82p 0 200p 0]
vpwl40 (key40 0) vsource type=pwl pwlperiod=100 wave=[0n 0 2.82p 1 100p 1 102.82p 0 200p 0]
vpwl41 (key41 0) vsource type=pwl pwlperiod=100 wave=[0n 0 2.82p 1 100p 1 102.82p 0 200p 0]
vpwl42 (key42 0) vsource type=pwl pwlperiod=100 wave=[0n 0 2.82p 1 100p 1 102.82p 0 200p 0]
vpwl43 (key43 0) vsource type=pwl pwlperiod=100 wave=[0n 0 2.82p 1 100p 1 102.82p 0 200p 0]
vpwl44 (key44 0) vsource type=pwl pwlperiod=100 wave=[0n 0 2.82p 1 100p 1 102.82p 0 200p 0]
vpwl45 (key45 0) vsource type=pwl pwlperiod=100 wave=[0n 0 2.82p 1 100p 1 102.82p 0 200p 0]
vpwl46 (key46 0) vsource type=pwl pwlperiod=100 wave=[0n 0 2.82p 1 100p 1 102.82p 0 200p 0]
vpwl47 (key47 0) vsource type=pwl pwlperiod=100 wave=[0n 0 2.82p 1 100p 1 102.82p 0 200p 0]
vpwl48 (key48 0) vsource type=pwl pwlperiod=100 wave=[0n 0 2.82p 1 100p 1 102.82p 0 200p 0]
vpwl49 (key49 0) vsource type=pwl pwlperiod=100 wave=[0n 0 2.82p 1 100p 1 102.82p 0 200p 0]
vpwl50 (key50 0) vsource type=pwl pwlperiod=100 wave=[0n 0 2.82p 1 100p 1 102.82p 0 200p 0]
vpwl51 (key51 0) vsource type=pwl pwlperiod=100 wave=[0n 0 2.82p 1 100p 1 102.82p 0 200p 0]
vpwl52 (key52 0) vsource type=pwl pwlperiod=100 wave=[0n 0 2.82p 1 100p 1 102.82p 0 200p 0]
vpwl53 (key53 0) vsource type=pwl pwlperiod=100 wave=[0n 0 2.82p 1 100p 1 102.82p 0 200p 0]
vpwl54 (key54 0) vsource type=pwl pwlperiod=100 wave=[0n 0 2.82p 1 100p 1 102.82p 0 200p 0]
vpwl55 (key55 0) vsource type=pwl pwlperiod=100 wave=[0n 0 2.82p 1 100p 1 102.82p 0 200p 0]
vpwl56 (key56 0) vsource type=pwl pwlperiod=100 wave=[0n 0 2.82p 1 100p 1 102.82p 0 200p 0]
vpwl57 (key57 0) vsource type=pwl pwlperiod=100 wave=[0n 0 2.82p 1 100p 1 102.82p 0 200p 0]
vpwl58 (key58 0) vsource type=pwl pwlperiod=100 wave=[0n 0 2.82p 1 100p 1 102.82p 0 200p 0]
vpwl59 (key59 0) vsource type=pwl pwlperiod=100 wave=[0n 0 2.82p 1 100p 1 102.82p 0 200p 0]
vpwl60 (key60 0) vsource type=pwl pwlperiod=100 wave=[0n 0 2.82p 1 100p 1 102.82p 0 200p 0]
vpwl61 (key61 0) vsource type=pwl pwlperiod=100 wave=[0n 0 2.82p 1 100p 1 102.82p 0 200p 0]
vpwl62 (key62 0) vsource type=pwl pwlperiod=100 wave=[0n 0 2.82p 1 100p 1 102.82p 0 200p 0]
vpwl63 (key63 0) vsource type=pwl pwlperiod=100 wave=[0n 0 2.82p 1 100p 1 102.82p 0 200p 0]
vpwl64 (key64 0) vsource type=pwl pwlperiod=100 wave=[0n 0 2.82p 1 100p 1 102.82p 0 200p 0]
vpwl65 (key65 0) vsource type=pwl pwlperiod=100 wave=[0n 0 2.82p 1 100p 1 102.82p 0 200p 0]
vpwl66 (key66 0) vsource type=pwl pwlperiod=100 wave=[0n 0 2.82p 1 100p 1 102.82p 0 200p 0]
vpwl67 (key67 0) vsource type=pwl pwlperiod=100 wave=[0n 0 2.82p 1 100p 1 102.82p 0 200p 0]
vpwl68 (key68 0) vsource type=pwl pwlperiod=100 wave=[0n 0 2.82p 1 100p 1 102.82p 0 200p 0]
vpwl69 (key69 0) vsource type=pwl pwlperiod=100 wave=[0n 0 2.82p 1 100p 1 102.82p 0 200p 0]
vpwl70 (key70 0) vsource type=pwl pwlperiod=100 wave=[0n 0 2.82p 1 100p 1 102.82p 0 200p 0]
vpwl71 (key71 0) vsource type=pwl pwlperiod=100 wave=[0n 0 2.82p 1 100p 1 102.82p 0 200p 0]
vpwl72 (key72 0) vsource type=pwl pwlperiod=100 wave=[0n 0 2.82p 1 100p 1 102.82p 0 200p 0]
vpwl73 (key73 0) vsource type=pwl pwlperiod=100 wave=[0n 0 2.82p 1 100p 1 102.82p 0 200p 0]
vpwl74 (key74 0) vsource type=pwl pwlperiod=100 wave=[0n 0 2.82p 1 100p 1 102.82p 0 200p 0]
vpwl75 (key75 0) vsource type=pwl pwlperiod=100 wave=[0n 0 2.82p 1 100p 1 102.82p 0 200p 0]
vpwl76 (key76 0) vsource type=pwl pwlperiod=100 wave=[0n 0 2.82p 1 100p 1 102.82p 0 200p 0]
vpwl77 (key77 0) vsource type=pwl pwlperiod=100 wave=[0n 0 2.82p 1 100p 1 102.82p 0 200p 0]
vpwl78 (key78 0) vsource type=pwl pwlperiod=100 wave=[0n 0 2.82p 1 100p 1 102.82p 0 200p 0]
vpwl79 (key79 0) vsource type=pwl pwlperiod=100 wave=[0n 0 2.82p 1 100p 1 102.82p 0 200p 0]
vpwl80 (key80 0) vsource type=pwl pwlperiod=100 wave=[0n 0 2.82p 1 100p 1 102.82p 0 200p 0]
vpwl81 (key81 0) vsource type=pwl pwlperiod=100 wave=[0n 0 2.82p 1 100p 1 102.82p 0 200p 0]
vpwl82 (key82 0) vsource type=pwl pwlperiod=100 wave=[0n 0 2.82p 1 100p 1 102.82p 0 200p 0]
vpwl83 (key83 0) vsource type=pwl pwlperiod=100 wave=[0n 0 2.82p 1 100p 1 102.82p 0 200p 0]
vpwl84 (key84 0) vsource type=pwl pwlperiod=100 wave=[0n 0 2.82p 1 100p 1 102.82p 0 200p 0]
vpwl85 (key85 0) vsource type=pwl pwlperiod=100 wave=[0n 0 2.82p 1 100p 1 102.82p 0 200p 0]
vpwl86 (key86 0) vsource type=pwl pwlperiod=100 wave=[0n 0 2.82p 1 100p 1 102.82p 0 200p 0]
vpwl87 (key87 0) vsource type=pwl pwlperiod=100 wave=[0n 0 2.82p 1 100p 1 102.82p 0 200p 0]
vpwl88 (key88 0) vsource type=pwl pwlperiod=100 wave=[0n 0 2.82p 1 100p 1 102.82p 0 200p 0]
vpwl89 (key89 0) vsource type=pwl pwlperiod=100 wave=[0n 0 2.82p 1 100p 1 102.82p 0 200p 0]
vpwl90 (key90 0) vsource type=pwl pwlperiod=100 wave=[0n 0 2.82p 1 100p 1 102.82p 0 200p 0]
vpwl91 (key91 0) vsource type=pwl pwlperiod=100 wave=[0n 0 2.82p 1 100p 1 102.82p 0 200p 0]
vpwl92 (key92 0) vsource type=pwl pwlperiod=100 wave=[0n 0 2.82p 1 100p 1 102.82p 0 200p 0]
vpwl93 (key93 0) vsource type=pwl pwlperiod=100 wave=[0n 0 2.82p 1 100p 1 102.82p 0 200p 0]
vpwl94 (key94 0) vsource type=pwl pwlperiod=100 wave=[0n 0 2.82p 1 100p 1 102.82p 0 200p 0]
vpwl95 (key95 0) vsource type=pwl pwlperiod=100 wave=[0n 0 2.82p 1 100p 1 102.82p 0 200p 0]
vpwl96 (key96 0) vsource type=pwl pwlperiod=100 wave=[0n 0 2.82p 1 100p 1 102.82p 0 200p 0]
vpwl97 (key97 0) vsource type=pwl pwlperiod=100 wave=[0n 0 2.82p 1 100p 1 102.82p 0 200p 0]
vpwl98 (key98 0) vsource type=pwl pwlperiod=100 wave=[0n 0 2.82p 1 100p 1 102.82p 0 200p 0]
vpwl99 (key99 0) vsource type=pwl pwlperiod=100 wave=[0n 0 2.82p 1 100p 1 102.82p 0 200p 0]

Transient_Analysis1 tran start=0 stop=200ps step=10ps

save bin0 bin1 bin2
