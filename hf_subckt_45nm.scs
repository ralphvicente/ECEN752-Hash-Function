simulator lang=spectre

include "~/ECEN752/45nm_HP.pm"
include "~/ECEN752/param.scs"

parameters wn=45n lmin=45n wp=90n lp=45n ln=45n

//AND2 gate
subckt AND2 (A B out VDD VSS)
parameters wn=45n lmin=45n wp=45n lp=45n ln=45n
P1 (outbar B VDD VDD) pmos w=wp l=lp as=wp*1.5*lp ad=wp*1.5*lp ps=wp+3*lp pd=wp+3*lp
P2 (outbar A VDD VDD) pmos w=wp l=lp as=wp*1.5*lp ad=wp*1.5*lp ps=wp+3*lp pd=wp+3*lp
N1 (net1 B VSS VSS) nmos w=wn l=ln as=wn*1.5*ln ad=wn*1.5*ln ps=wn+3*ln pd=wn+3*ln
N2 (outbar A net1 VSS) nmos w=wn l=ln as=wn*1.5*ln ad=wn*1.5*ln ps=wn+3*ln pd=wn+3*ln

M1 out outbar VDD VDD pmos w=wp l=lp as=wp*1.5*lp ad=wp*1.5*lp ps=wp+3*lp pd=wp+3*lp
M2 out outbar VSS VSS nmos w=wn l=lp as=wn*1.5*ln ad=wn*1.5*ln ps=wn+3*ln pd=wn+3*ln

ends AND2

//XOR2 gate
subckt XOR2(A B out VDD VSS)
parameters wn=45n lmin=45n wp=90n lp=45n ln=45n
M1 Abar A VDD VDD pmos w=wp l=lp as=wp*1.5*lp ad=wp*1.5*lp ps=wp+3*lp pd=wp+3*lp
M3 Abar A VSS VSS nmos w=wn l=ln as=wn*1.5*ln ad=wn*1.5*ln ps=wn+3*ln pd=wn+3*ln

M4 Bbar B VDD VDD pmos w=wp l=lp as=wp*1.5*lp ad=wp*1.5*lp ps=wp+3*lp pd=wp+3*lp
M2 Bbar B VSS VSS nmos w=wn l=ln as=wn*1.5*ln ad=wn*1.5*ln ps=wn+3*ln pd=wn+3*ln

P1 (net1 B VDD VDD) pmos l=22n w=wp l=lp as=wp*1.5*lp ad=wp*1.5*lp ps=wp+3*lp pd=wp+3*lp
P2 (net2 Bbar VDD VDD) pmos l=22n w=wp l=lp as=wp*1.5*lp ad=wp*1.5*lp ps=wp+3*lp pd=wp+3*lp
P3 (out Abar net1 VDD) pmos l=22n w=wp l=lp as=wp*1.5*lp ad=wp*1.5*lp ps=wp+3*lp pd=wp+3*lp
P4 (out A net2 VDD) pmos l=22n w=wp l=lp as=wp*1.5*lp ad=wp*1.5*lp ps=wp+3*lp pd=wp+3*lp

N1 (out Abar net3 VSS) nmos w=wn l=ln as=wn*1.5*ln ad=wn*1.5*ln ps=wn+3*ln pd=wn+3*ln
N2 (out A net4 VSS) nmos w=wn l=ln as=wn*1.5*ln ad=wn*1.5*ln ps=wn+3*ln pd=wn+3*ln
N3 (net3 Bbar VSS VSS) nmos w=wn l=ln as=wn*1.5*ln ad=wn*1.5*ln ps=wn+3*ln pd=wn+3*ln
N4 (net4 B VSS VSS) nmos w=wn l=ln as=wn*1.5*ln ad=wn*1.5*ln ps=wn+3*ln pd=wn+3*ln
ends XOR2

//100 INPUT bitwise XOR
subckt XOR100(A1 A2 A3 A4 A5 A6 A7 A8 A9 A10 A11 A12 A13 A14 A15 A16 A17 A18 A19 A20 A21 A22 A23 A24 A25 A26 A27 A28 A29 A30 A31 A32 A33 A34 A35 A36 A37 A38 A39 A40 A41 A42 A43 A44 A45 A46 A47 A48 A49 A50 A51 A52 A53 A54 A55 A56 A57 A58 A59 A60 A61 A62 A63 A64 A65 A66 A67 A68 A69 A70 A71 A72 A73 A74 A75 A76 A77 A78 A79 A80 A81 A82 A83 A84 A85 A86 A87 A88 A89 A90 A91 A92 A93 A94 A95 A96 A97 A98 A99 A100 out VDD VSS)
parameters wn=45n lmin=45n wp=90n lp=45n ln=45n
X1 (A1 A2 net1 VDD VSS) XOR2
X2 (net1 A3 net2 VDD VSS) XOR2
X3 (net2 A4 net3 VDD VSS) XOR2
X4 (net3 A5 net4 VDD VSS) XOR2
X5 (net4 A6 net5 VDD VSS) XOR2
X6 (net5 A7 net6 VDD VSS) XOR2
X7 (net6 A8 net7 VDD VSS) XOR2
X8 (net7 A9 net8 VDD VSS) XOR2
X9 (net8 A10 net9 VDD VSS) XOR2
X10 (net9 A11 net10 VDD VSS) XOR2
X11 (net10 A12 net11 VDD VSS) XOR2
X12 (net11 A13 net12 VDD VSS) XOR2
X13 (net12 A14 net13 VDD VSS) XOR2
X14 (net13 A15 net14 VDD VSS) XOR2
X15 (net14 A16 net15 VDD VSS) XOR2
X16 (net15 A17 net16 VDD VSS) XOR2
X17 (net16 A18 net17 VDD VSS) XOR2
X18 (net17 A19 net18 VDD VSS) XOR2
X19 (net18 A20 net19 VDD VSS) XOR2
X20 (net19 A21 net20 VDD VSS) XOR2
X21 (net20 A22 net21 VDD VSS) XOR2
X22 (net21 A23 net22 VDD VSS) XOR2
X23 (net22 A24 net23 VDD VSS) XOR2
X24 (net23 A25 net24 VDD VSS) XOR2
X25 (net24 A26 net25 VDD VSS) XOR2
X26 (net25 A27 net26 VDD VSS) XOR2
X27 (net26 A28 net27 VDD VSS) XOR2
X28 (net27 A29 net28 VDD VSS) XOR2
X29 (net28 A30 net29 VDD VSS) XOR2
X30 (net29 A31 net30 VDD VSS) XOR2
X31 (net30 A32 net31 VDD VSS) XOR2
X32 (net31 A33 net32 VDD VSS) XOR2
X33 (net32 A34 net33 VDD VSS) XOR2
X34 (net33 A35 net34 VDD VSS) XOR2
X35 (net34 A36 net35 VDD VSS) XOR2
X36 (net35 A37 net36 VDD VSS) XOR2
X37 (net36 A38 net37 VDD VSS) XOR2
X38 (net37 A39 net38 VDD VSS) XOR2
X39 (net38 A40 net39 VDD VSS) XOR2
X40 (net39 A41 net40 VDD VSS) XOR2
X41 (net40 A42 net41 VDD VSS) XOR2
X42 (net41 A43 net42 VDD VSS) XOR2
X43 (net42 A44 net43 VDD VSS) XOR2
X44 (net43 A45 net44 VDD VSS) XOR2
X45 (net44 A46 net45 VDD VSS) XOR2
X46 (net45 A47 net46 VDD VSS) XOR2
X47 (net46 A48 net47 VDD VSS) XOR2
X48 (net47 A49 net48 VDD VSS) XOR2
X49 (net48 A50 net49 VDD VSS) XOR2
X50 (net49 A51 net50 VDD VSS) XOR2
X51 (net50 A52 net51 VDD VSS) XOR2
X52 (net51 A53 net52 VDD VSS) XOR2
X53 (net52 A54 net53 VDD VSS) XOR2
X54 (net53 A55 net54 VDD VSS) XOR2
X55 (net54 A56 net55 VDD VSS) XOR2
X56 (net55 A57 net56 VDD VSS) XOR2
X57 (net56 A58 net57 VDD VSS) XOR2
X58 (net57 A59 net58 VDD VSS) XOR2
X59 (net58 A60 net59 VDD VSS) XOR2
X60 (net59 A61 net60 VDD VSS) XOR2
X61 (net60 A62 net61 VDD VSS) XOR2
X62 (net61 A63 net62 VDD VSS) XOR2
X63 (net62 A64 net63 VDD VSS) XOR2
X64 (net63 A65 net64 VDD VSS) XOR2
X65 (net64 A66 net65 VDD VSS) XOR2
X66 (net65 A67 net66 VDD VSS) XOR2
X67 (net66 A68 net67 VDD VSS) XOR2
X68 (net67 A69 net68 VDD VSS) XOR2
X69 (net68 A70 net69 VDD VSS) XOR2
X70 (net69 A71 net70 VDD VSS) XOR2
X71 (net70 A72 net71 VDD VSS) XOR2
X72 (net71 A73 net72 VDD VSS) XOR2
X73 (net72 A74 net73 VDD VSS) XOR2
X74 (net73 A75 net74 VDD VSS) XOR2
X75 (net74 A76 net75 VDD VSS) XOR2
X76 (net75 A77 net76 VDD VSS) XOR2
X77 (net76 A78 net77 VDD VSS) XOR2
X78 (net77 A79 net78 VDD VSS) XOR2
X79 (net78 A80 net79 VDD VSS) XOR2
X80 (net79 A81 net80 VDD VSS) XOR2
X81 (net80 A82 net81 VDD VSS) XOR2
X82 (net81 A83 net82 VDD VSS) XOR2
X83 (net82 A84 net83 VDD VSS) XOR2
X84 (net83 A85 net84 VDD VSS) XOR2
X85 (net84 A86 net85 VDD VSS) XOR2
X86 (net85 A87 net86 VDD VSS) XOR2
X87 (net86 A88 net87 VDD VSS) XOR2
X88 (net87 A89 net88 VDD VSS) XOR2
X89 (net88 A90 net89 VDD VSS) XOR2
X90 (net89 A91 net90 VDD VSS) XOR2
X91 (net90 A92 net91 VDD VSS) XOR2
X92 (net91 A93 net92 VDD VSS) XOR2
X93 (net92 A94 net93 VDD VSS) XOR2
X94 (net93 A95 net94 VDD VSS) XOR2
X95 (net94 A96 net95 VDD VSS) XOR2
X96 (net95 A97 net96 VDD VSS) XOR2
X97 (net96 A98 net97 VDD VSS) XOR2
X98 (net97 A99 net98 VDD VSS) XOR2
X99 (net98 A100 out VDD VSS) XOR2
ends XOR100

//row for the Q Matrix circuit (It's actually a column in actual Q-matrix)
subckt row(key0 key1 key2 key3 key4 key5 key6 key7 key8 key9 key10 key11 key12 key13 key14 key15 key16 key17 key18 key19 key20 key21 key22 key23 key24 key25 key26 key27 key28 key29 key30 key31 key32 key33 key34 key35 key36 key37 key38 key39 key40 key41 key42 key43 key44 key45 key46 key47 key48 key49 key50 key51 key52 key53 key54 key55 key56 key57 key58 key59 key60 key61 key62 key63 key64 key65 key66 key67 key68 key69 key70 key71 key72 key73 key74 key75 key76 key77 key78 key79 key80 key81 key82 key83 key84 key85 key86 key87 key88 key89 key90 key91 key92 key93 key94 key95 key96 key97 key98 key99 q0 q1 q2 q3 q4 q5 q6 q7 q8 q9 q10 q11 q12 q13 q14 q15 q16 q17 q18 q19 q20 q21 q22 q23 q24 q25 q26 q27 q28 q29 q30 q31 q32 q33 q34 q35 q36 q37 q38 q39 q40 q41 q42 q43 q44 q45 q46 q47 q48 q49 q50 q51 q52 q53 q54 q55 q56 q57 q58 q59 q60 q61 q62 q63 q64 q65 q66 q67 q68 q69 q70 q71 q72 q73 q74 q75 q76 q77 q78 q79 q80 q81 q82 q83 q84 q85 q86 q87 q88 q89 q90 q91 q92 q93 q94 q95 q96 q97 q98 q99 out0 out1 out2 out3 out4 out5 out6 out7 out8 out9 out10 out11 out12 out13 out14 out15 out16 out17 out18 out19 out20 out21 out22 out23 out24 out25 out26 out27 out28 out29 out30 out31 out32 out33 out34 out35 out36 out37 out38 out39 out40 out41 out42 out43 out44 out45 out46 out47 out48 out49 out50 out51 out52 out53 out54 out55 out56 out57 out58 out59 out60 out61 out62 out63 out64 out65 out66 out67 out68 out69 out70 out71 out72 out73 out74 out75 out76 out77 out78 out79 out80 out81 out82 out83 out84 out85 out86 out87 out88 out89 out90 out91 out92 out93 out94 out95 out96 out97 out98 out99 VDD VSS)
X1 (q0 key0 out0 VDD VSS) AND2
X2 (q1 key1 out1 VDD VSS) AND2
X3 (q2 key2 out2 VDD VSS) AND2
X4 (q3 key3 out3 VDD VSS) AND2
X5 (q4 key4 out4 VDD VSS) AND2
X6 (q5 key5 out5 VDD VSS) AND2
X7 (q6 key6 out6 VDD VSS) AND2
X8 (q7 key7 out7 VDD VSS) AND2
X9 (q8 key8 out8 VDD VSS) AND2
X10 (q9 key9 out9 VDD VSS) AND2
X11 (q10 key10 out10 VDD VSS) AND2
X12 (q11 key11 out11 VDD VSS) AND2
X13 (q12 key12 out12 VDD VSS) AND2
X14 (q13 key13 out13 VDD VSS) AND2
X15 (q14 key14 out14 VDD VSS) AND2
X16 (q15 key15 out15 VDD VSS) AND2
X17 (q16 key16 out16 VDD VSS) AND2
X18 (q17 key17 out17 VDD VSS) AND2
X19 (q18 key18 out18 VDD VSS) AND2
X20 (q19 key19 out19 VDD VSS) AND2
X21 (q20 key20 out20 VDD VSS) AND2
X22 (q21 key21 out21 VDD VSS) AND2
X23 (q22 key22 out22 VDD VSS) AND2
X24 (q23 key23 out23 VDD VSS) AND2
X25 (q24 key24 out24 VDD VSS) AND2
X26 (q25 key25 out25 VDD VSS) AND2
X27 (q26 key26 out26 VDD VSS) AND2
X28 (q27 key27 out27 VDD VSS) AND2
X29 (q28 key28 out28 VDD VSS) AND2
X30 (q29 key29 out29 VDD VSS) AND2
X31 (q30 key30 out30 VDD VSS) AND2
X32 (q31 key31 out31 VDD VSS) AND2
X33 (q32 key32 out32 VDD VSS) AND2
X34 (q33 key33 out33 VDD VSS) AND2
X35 (q34 key34 out34 VDD VSS) AND2
X36 (q35 key35 out35 VDD VSS) AND2
X37 (q36 key36 out36 VDD VSS) AND2
X38 (q37 key37 out37 VDD VSS) AND2
X39 (q38 key38 out38 VDD VSS) AND2
X40 (q39 key39 out39 VDD VSS) AND2
X41 (q40 key40 out40 VDD VSS) AND2
X42 (q41 key41 out41 VDD VSS) AND2
X43 (q42 key42 out42 VDD VSS) AND2
X44 (q43 key43 out43 VDD VSS) AND2
X45 (q44 key44 out44 VDD VSS) AND2
X46 (q45 key45 out45 VDD VSS) AND2
X47 (q46 key46 out46 VDD VSS) AND2
X48 (q47 key47 out47 VDD VSS) AND2
X49 (q48 key48 out48 VDD VSS) AND2
X50 (q49 key49 out49 VDD VSS) AND2
X51 (q50 key50 out50 VDD VSS) AND2
X52 (q51 key51 out51 VDD VSS) AND2
X53 (q52 key52 out52 VDD VSS) AND2
X54 (q53 key53 out53 VDD VSS) AND2
X55 (q54 key54 out54 VDD VSS) AND2
X56 (q55 key55 out55 VDD VSS) AND2
X57 (q56 key56 out56 VDD VSS) AND2
X58 (q57 key57 out57 VDD VSS) AND2
X59 (q58 key58 out58 VDD VSS) AND2
X60 (q59 key59 out59 VDD VSS) AND2
X61 (q60 key60 out60 VDD VSS) AND2
X62 (q61 key61 out61 VDD VSS) AND2
X63 (q62 key62 out62 VDD VSS) AND2
X64 (q63 key63 out63 VDD VSS) AND2
X65 (q64 key64 out64 VDD VSS) AND2
X66 (q65 key65 out65 VDD VSS) AND2
X67 (q66 key66 out66 VDD VSS) AND2
X68 (q67 key67 out67 VDD VSS) AND2
X69 (q68 key68 out68 VDD VSS) AND2
X70 (q69 key69 out69 VDD VSS) AND2
X71 (q70 key70 out70 VDD VSS) AND2
X72 (q71 key71 out71 VDD VSS) AND2
X73 (q72 key72 out72 VDD VSS) AND2
X74 (q73 key73 out73 VDD VSS) AND2
X75 (q74 key74 out74 VDD VSS) AND2
X76 (q75 key75 out75 VDD VSS) AND2
X77 (q76 key76 out76 VDD VSS) AND2
X78 (q77 key77 out77 VDD VSS) AND2
X79 (q78 key78 out78 VDD VSS) AND2
X80 (q79 key79 out79 VDD VSS) AND2
X81 (q80 key80 out80 VDD VSS) AND2
X82 (q81 key81 out81 VDD VSS) AND2
X83 (q82 key82 out82 VDD VSS) AND2
X84 (q83 key83 out83 VDD VSS) AND2
X85 (q84 key84 out84 VDD VSS) AND2
X86 (q85 key85 out85 VDD VSS) AND2
X87 (q86 key86 out86 VDD VSS) AND2
X88 (q87 key87 out87 VDD VSS) AND2
X89 (q88 key88 out88 VDD VSS) AND2
X90 (q89 key89 out89 VDD VSS) AND2
X91 (q90 key90 out90 VDD VSS) AND2
X92 (q91 key91 out91 VDD VSS) AND2
X93 (q92 key92 out92 VDD VSS) AND2
X94 (q93 key93 out93 VDD VSS) AND2
X95 (q94 key94 out94 VDD VSS) AND2
X96 (q95 key95 out95 VDD VSS) AND2
X97 (q96 key96 out96 VDD VSS) AND2
X98 (q97 key97 out97 VDD VSS) AND2
X99 (q98 key98 out98 VDD VSS) AND2
X100 (q99 key99 out99 VDD VSS) AND2
ends row
